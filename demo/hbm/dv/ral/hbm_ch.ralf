# Generated by autowire plugin wishbone (hbm_ch). Do not edit.
# Register types are shared. Each bus is one block.
# TagFromAddr aliases are separate instances of that block or register.
# A pass-through child is not split; the parent names each copy.

register aword_ID {
	bytes 4;
	field magic @0 { bits 16; access ro; reset 0xa570; }
	field version @16 { bits 16; access ro; reset 0x1; }
}
register aword_STATUS {
	bytes 4;
	field cal_done @0 { bits 1; access ro; reset 0x0; }
	field err_code @8 { bits 8; access ro; reset 0x0; }
}
register aword_TIMING { # shadow pstate
	bytes 4;
	field trcd @0 { bits 8; access rw; reset 0xc; }
	field trp @8 { bits 8; access rw; reset 0xc; }
}
register aword_DRIVE { # shadow pstate
	bytes 4;
	field ca_drive @0 { bits 4; access rw; reset 0x4; }
}
register dword_ID {
	bytes 4;
	field magic @0 { bits 16; access ro; reset 0xd010; }
	field version @16 { bits 16; access ro; reset 0x1; }
}
register dword_STATUS {
	bytes 4;
	field train_done @0 { bits 1; access ro; reset 0x0; }
	field eye_width @8 { bits 8; access ro; reset 0x0; }
}
register dword_VREF { # shadow pstate
	bytes 4;
	field level @0 { bits 7; access rw; reset 0x30; }
}
register dword_EQ { # shadow pstate
	bytes 4;
	field tap0 @0 { bits 5; access rw; reset 0x2; }
	field tap1 @8 { bits 5; access rw; reset 0x1; }
}
block hbm_ch {
	bytes 4;
	register aword_ID aword_ID @0x0;
	register aword_STATUS aword_STATUS @0x4;
	register aword_TIMING aword_TIMING @0x8;
	register aword_DRIVE aword_DRIVE @0xc;
	register dword_ID dword0_ID @0x100;
	register dword_STATUS dword0_STATUS @0x104;
	register dword_VREF dword0_VREF @0x108;
	register dword_EQ dword0_EQ @0x10c;
	register dword_ID dword1_ID @0x200;
	register dword_STATUS dword1_STATUS @0x204;
	register dword_VREF dword1_VREF @0x208;
	register dword_EQ dword1_EQ @0x20c;
	# dword_bcast @0x300 broadcast dword_all: one write at this window hits every subscriber
}
