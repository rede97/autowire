# Generated by autowire plugin wishbone (hbm). Do not edit.
# Register types are shared. Each bus is one block.
# TagFromAddr aliases are separate instances of that block or register.
# A pass-through child is not split; the parent names each copy.

register aword_ID {
	bytes 4;
	field magic @0 { bits 16; access ro; reset 0xa570; }
	field version @16 { bits 16; access ro; reset 0x1; }
}
register aword_STATUS {
	bytes 4;
	field cal_done @0 { bits 1; access ro; reset 0x0; }
	field err_code @8 { bits 8; access ro; reset 0x0; }
}
register aword_TIMING { # shadow pstate
	bytes 4;
	field trcd @0 { bits 8; access rw; reset 0xc; }
	field trp @8 { bits 8; access rw; reset 0xc; }
}
register aword_DRIVE { # shadow pstate
	bytes 4;
	field ca_drive @0 { bits 4; access rw; reset 0x4; }
}
register dword_ID {
	bytes 4;
	field magic @0 { bits 16; access ro; reset 0xd010; }
	field version @16 { bits 16; access ro; reset 0x1; }
}
register dword_STATUS {
	bytes 4;
	field train_done @0 { bits 1; access ro; reset 0x0; }
	field eye_width @8 { bits 8; access ro; reset 0x0; }
}
register dword_VREF { # shadow pstate
	bytes 4;
	field level @0 { bits 7; access rw; reset 0x30; }
}
register dword_EQ { # shadow pstate
	bytes 4;
	field tap0 @0 { bits 5; access rw; reset 0x2; }
	field tap1 @8 { bits 5; access rw; reset 0x1; }
}
block hbm_ch {
	bytes 4;
	register aword_ID aword_ID @0x0;
	register aword_STATUS aword_STATUS @0x4;
	register aword_TIMING aword_TIMING @0x8;
	register aword_DRIVE aword_DRIVE @0xc;
	register dword_ID dword0_ID @0x100;
	register dword_STATUS dword0_STATUS @0x104;
	register dword_VREF dword0_VREF @0x108;
	register dword_EQ dword0_EQ @0x10c;
	register dword_ID dword1_ID @0x200;
	register dword_STATUS dword1_STATUS @0x204;
	register dword_VREF dword1_VREF @0x208;
	register dword_EQ dword1_EQ @0x20c;
	# dword_bcast @0x300 broadcast dword_all: one write at this window hits every subscriber
}

block hbm {
	bytes 4;
	# ch0_pstate0: pstate=0
	block hbm_ch ch0_pstate0 @0x0;
	# ch0_pstate1: pstate=1
	block hbm_ch ch0_pstate1 @0x40000000;
	# ch0_pstate2: pstate=2
	block hbm_ch ch0_pstate2 @0x80000000;
	# ch0_pstate3: pstate=3
	block hbm_ch ch0_pstate3 @0xc0000000;
	# ch1_pstate0: pstate=0
	block hbm_ch ch1_pstate0 @0x1000;
	# ch1_pstate1: pstate=1
	block hbm_ch ch1_pstate1 @0x40001000;
	# ch1_pstate2: pstate=2
	block hbm_ch ch1_pstate2 @0x80001000;
	# ch1_pstate3: pstate=3
	block hbm_ch ch1_pstate3 @0xc0001000;
	# ch2_pstate0: pstate=0
	block hbm_ch ch2_pstate0 @0x2000;
	# ch2_pstate1: pstate=1
	block hbm_ch ch2_pstate1 @0x40002000;
	# ch2_pstate2: pstate=2
	block hbm_ch ch2_pstate2 @0x80002000;
	# ch2_pstate3: pstate=3
	block hbm_ch ch2_pstate3 @0xc0002000;
	# ch3_pstate0: pstate=0
	block hbm_ch ch3_pstate0 @0x3000;
	# ch3_pstate1: pstate=1
	block hbm_ch ch3_pstate1 @0x40003000;
	# ch3_pstate2: pstate=2
	block hbm_ch ch3_pstate2 @0x80003000;
	# ch3_pstate3: pstate=3
	block hbm_ch ch3_pstate3 @0xc0003000;
	# ch4_pstate0: pstate=0
	block hbm_ch ch4_pstate0 @0x4000;
	# ch4_pstate1: pstate=1
	block hbm_ch ch4_pstate1 @0x40004000;
	# ch4_pstate2: pstate=2
	block hbm_ch ch4_pstate2 @0x80004000;
	# ch4_pstate3: pstate=3
	block hbm_ch ch4_pstate3 @0xc0004000;
	# ch5_pstate0: pstate=0
	block hbm_ch ch5_pstate0 @0x5000;
	# ch5_pstate1: pstate=1
	block hbm_ch ch5_pstate1 @0x40005000;
	# ch5_pstate2: pstate=2
	block hbm_ch ch5_pstate2 @0x80005000;
	# ch5_pstate3: pstate=3
	block hbm_ch ch5_pstate3 @0xc0005000;
	# ch6_pstate0: pstate=0
	block hbm_ch ch6_pstate0 @0x6000;
	# ch6_pstate1: pstate=1
	block hbm_ch ch6_pstate1 @0x40006000;
	# ch6_pstate2: pstate=2
	block hbm_ch ch6_pstate2 @0x80006000;
	# ch6_pstate3: pstate=3
	block hbm_ch ch6_pstate3 @0xc0006000;
	# ch7_pstate0: pstate=0
	block hbm_ch ch7_pstate0 @0x7000;
	# ch7_pstate1: pstate=1
	block hbm_ch ch7_pstate1 @0x40007000;
	# ch7_pstate2: pstate=2
	block hbm_ch ch7_pstate2 @0x80007000;
	# ch7_pstate3: pstate=3
	block hbm_ch ch7_pstate3 @0xc0007000;
	# ch8_pstate0: pstate=0
	block hbm_ch ch8_pstate0 @0x8000;
	# ch8_pstate1: pstate=1
	block hbm_ch ch8_pstate1 @0x40008000;
	# ch8_pstate2: pstate=2
	block hbm_ch ch8_pstate2 @0x80008000;
	# ch8_pstate3: pstate=3
	block hbm_ch ch8_pstate3 @0xc0008000;
	# ch9_pstate0: pstate=0
	block hbm_ch ch9_pstate0 @0x9000;
	# ch9_pstate1: pstate=1
	block hbm_ch ch9_pstate1 @0x40009000;
	# ch9_pstate2: pstate=2
	block hbm_ch ch9_pstate2 @0x80009000;
	# ch9_pstate3: pstate=3
	block hbm_ch ch9_pstate3 @0xc0009000;
	# ch10_pstate0: pstate=0
	block hbm_ch ch10_pstate0 @0xa000;
	# ch10_pstate1: pstate=1
	block hbm_ch ch10_pstate1 @0x4000a000;
	# ch10_pstate2: pstate=2
	block hbm_ch ch10_pstate2 @0x8000a000;
	# ch10_pstate3: pstate=3
	block hbm_ch ch10_pstate3 @0xc000a000;
	# ch11_pstate0: pstate=0
	block hbm_ch ch11_pstate0 @0xb000;
	# ch11_pstate1: pstate=1
	block hbm_ch ch11_pstate1 @0x4000b000;
	# ch11_pstate2: pstate=2
	block hbm_ch ch11_pstate2 @0x8000b000;
	# ch11_pstate3: pstate=3
	block hbm_ch ch11_pstate3 @0xc000b000;
	# ch12_pstate0: pstate=0
	block hbm_ch ch12_pstate0 @0xc000;
	# ch12_pstate1: pstate=1
	block hbm_ch ch12_pstate1 @0x4000c000;
	# ch12_pstate2: pstate=2
	block hbm_ch ch12_pstate2 @0x8000c000;
	# ch12_pstate3: pstate=3
	block hbm_ch ch12_pstate3 @0xc000c000;
	# ch13_pstate0: pstate=0
	block hbm_ch ch13_pstate0 @0xd000;
	# ch13_pstate1: pstate=1
	block hbm_ch ch13_pstate1 @0x4000d000;
	# ch13_pstate2: pstate=2
	block hbm_ch ch13_pstate2 @0x8000d000;
	# ch13_pstate3: pstate=3
	block hbm_ch ch13_pstate3 @0xc000d000;
	# ch14_pstate0: pstate=0
	block hbm_ch ch14_pstate0 @0xe000;
	# ch14_pstate1: pstate=1
	block hbm_ch ch14_pstate1 @0x4000e000;
	# ch14_pstate2: pstate=2
	block hbm_ch ch14_pstate2 @0x8000e000;
	# ch14_pstate3: pstate=3
	block hbm_ch ch14_pstate3 @0xc000e000;
	# ch15_pstate0: pstate=0
	block hbm_ch ch15_pstate0 @0xf000;
	# ch15_pstate1: pstate=1
	block hbm_ch ch15_pstate1 @0x4000f000;
	# ch15_pstate2: pstate=2
	block hbm_ch ch15_pstate2 @0x8000f000;
	# ch15_pstate3: pstate=3
	block hbm_ch ch15_pstate3 @0xc000f000;
	# ch_bcast @0x10000 broadcast ch_all: one write at this window hits every subscriber
}
