# Generated by autowire plugin wishbone (soc_wb). Do not edit.
# Register types are shared. Each bus is one block.
# TagFromAddr aliases are separate instances of that block or register.
# A pass-through child is not split; the parent names each copy.

register sha256_CTRL {
	bytes 4;
	field soft_reset @0 { bits 1; access rw; reset 0x0; }
	field done_clear @1 { bits 1; access w1c; reset 0x0; }
	field busy @8 { bits 1; access ro; reset 0x0; }
	field done @9 { bits 1; access ro; reset 0x0; }
}
register sha256_HASH0 {
	bytes 4;
	field hash0 @0 { bits 32; access ro; reset 0x0; }
}
register sha256_HASH1 {
	bytes 4;
	field hash1 @0 { bits 32; access ro; reset 0x0; }
}
register sha256_HASH2 {
	bytes 4;
	field hash2 @0 { bits 32; access ro; reset 0x0; }
}
register sha256_HASH3 {
	bytes 4;
	field hash3 @0 { bits 32; access ro; reset 0x0; }
}
register sha256_HASH4 {
	bytes 4;
	field hash4 @0 { bits 32; access ro; reset 0x0; }
}
register sha256_HASH5 {
	bytes 4;
	field hash5 @0 { bits 32; access ro; reset 0x0; }
}
register sha256_HASH6 {
	bytes 4;
	field hash6 @0 { bits 32; access ro; reset 0x0; }
}
register sha256_HASH7 {
	bytes 4;
	field hash7 @0 { bits 32; access ro; reset 0x0; }
}
register smoke_ID {
	bytes 4;
	field magic @0 { bits 16; access ro; reset 0xa55a; }
	field version @16 { bits 16; access ro; reset 0x1; }
}
register smoke_STATUS {
	bytes 4;
	field busy @0 { bits 1; access ro; reset 0x0; }
	field code @8 { bits 8; access ro; reset 0x0; }
}
register smoke_CFG {
	bytes 4;
	field enable @0 { bits 1; access rw; reset 0x0; }
	field mode @8 { bits 3; access rw; reset 0x1; }
}
register smoke_FEED {
	bytes 4;
	field capture @0 { bits 16; access rw; reset 0x0; }
}
register smoke_FIFO {
	bytes 4;
	field data @0 { bits 32; access rw; reset 0x0; }
}
register smoke_CMD {
	bytes 4;
	field go @0 { bits 1; access w1c; reset 0x0; }
}
register smoke_IRQ {
	bytes 4;
	field sticky @0 { bits 1; access w1c; reset 0x0; }
}
register smoke_BANK { # shadow bank
	bytes 4;
	field cfg @0 { bits 8; access rw; reset 0x10; }
}
register smoke_BANKSEL {
	bytes 4;
	field bank_sel @0 { bits 2; access rw; reset 0x0; }
}
register smoke_ACTIVE {
	bytes 4;
	field value @0 { bits 8; access ro; reset 0x0; }
}
register smoke_FABRIC {
	bytes 4;
	field rb_grant_en @0 { bits 1; access rw; reset 0x0; }
}
register smoke_key_key_0 {
	bytes 4;
	field key_0 @0 { bits 32; access rw; reset 0x0; }
}
register smoke_key_key_1 {
	bytes 4;
	field key_1 @0 { bits 32; access rw; reset 0x0; }
}
register smoke_key_key_2 {
	bytes 4;
	field key_2 @0 { bits 32; access rw; reset 0x0; }
}
block sd_sha {
	bytes 4;
	register sha256_CTRL sha256_CTRL @0x40;
	register sha256_HASH0 sha256_HASH0 @0x44;
	register sha256_HASH1 sha256_HASH1 @0x48;
	register sha256_HASH2 sha256_HASH2 @0x4c;
	register sha256_HASH3 sha256_HASH3 @0x50;
	register sha256_HASH4 sha256_HASH4 @0x54;
	register sha256_HASH5 sha256_HASH5 @0x58;
	register sha256_HASH6 sha256_HASH6 @0x5c;
	register sha256_HASH7 sha256_HASH7 @0x60;
}

block soc_wb {
	bytes 4;
	# ch0_bank0: bank=0
	block sd_sha ch0_bank0 @0x3000000;
	# ch0_bank1: bank=1
	block sd_sha ch0_bank1 @0x43000000;
	# ch0_bank2: bank=2
	block sd_sha ch0_bank2 @0x83000000;
	# ch0_bank3: bank=3
	block sd_sha ch0_bank3 @0xc3000000;
	# ch1_bank0: bank=0
	block sd_sha ch1_bank0 @0x3001000;
	# ch1_bank1: bank=1
	block sd_sha ch1_bank1 @0x43001000;
	# ch1_bank2: bank=2
	block sd_sha ch1_bank2 @0x83001000;
	# ch1_bank3: bank=3
	block sd_sha ch1_bank3 @0xc3001000;
	# smoke_bank0: bank=0
	register smoke_ID smoke_bank0_ID @0x3006000;
	register smoke_STATUS smoke_bank0_STATUS @0x3006004;
	register smoke_CFG smoke_bank0_CFG @0x3006008;
	register smoke_FEED smoke_bank0_FEED @0x300600c;
	register smoke_FIFO smoke_bank0_FIFO @0x3006010;
	register smoke_CMD smoke_bank0_CMD @0x3006014;
	register smoke_IRQ smoke_bank0_IRQ @0x3006018;
	register smoke_BANK smoke_bank0_BANK @0x300601c;
	register smoke_BANKSEL smoke_bank0_BANKSEL @0x300602c;
	register smoke_ACTIVE smoke_bank0_ACTIVE @0x3006034;
	register smoke_FABRIC smoke_bank0_FABRIC @0x3006030;
	register smoke_key_key_0 smoke_bank0_key_key_0 @0x3006020;
	register smoke_key_key_1 smoke_bank0_key_key_1 @0x3006024;
	register smoke_key_key_2 smoke_bank0_key_key_2 @0x3006028;
	# smoke_bank1: bank=1
	register smoke_ID smoke_bank1_ID @0x43006000;
	register smoke_STATUS smoke_bank1_STATUS @0x43006004;
	register smoke_CFG smoke_bank1_CFG @0x43006008;
	register smoke_FEED smoke_bank1_FEED @0x4300600c;
	register smoke_FIFO smoke_bank1_FIFO @0x43006010;
	register smoke_CMD smoke_bank1_CMD @0x43006014;
	register smoke_IRQ smoke_bank1_IRQ @0x43006018;
	register smoke_BANK smoke_bank1_BANK @0x4300601c;
	register smoke_BANKSEL smoke_bank1_BANKSEL @0x4300602c;
	register smoke_ACTIVE smoke_bank1_ACTIVE @0x43006034;
	register smoke_FABRIC smoke_bank1_FABRIC @0x43006030;
	register smoke_key_key_0 smoke_bank1_key_key_0 @0x43006020;
	register smoke_key_key_1 smoke_bank1_key_key_1 @0x43006024;
	register smoke_key_key_2 smoke_bank1_key_key_2 @0x43006028;
	# smoke_bank2: bank=2
	register smoke_ID smoke_bank2_ID @0x83006000;
	register smoke_STATUS smoke_bank2_STATUS @0x83006004;
	register smoke_CFG smoke_bank2_CFG @0x83006008;
	register smoke_FEED smoke_bank2_FEED @0x8300600c;
	register smoke_FIFO smoke_bank2_FIFO @0x83006010;
	register smoke_CMD smoke_bank2_CMD @0x83006014;
	register smoke_IRQ smoke_bank2_IRQ @0x83006018;
	register smoke_BANK smoke_bank2_BANK @0x8300601c;
	register smoke_BANKSEL smoke_bank2_BANKSEL @0x8300602c;
	register smoke_ACTIVE smoke_bank2_ACTIVE @0x83006034;
	register smoke_FABRIC smoke_bank2_FABRIC @0x83006030;
	register smoke_key_key_0 smoke_bank2_key_key_0 @0x83006020;
	register smoke_key_key_1 smoke_bank2_key_key_1 @0x83006024;
	register smoke_key_key_2 smoke_bank2_key_key_2 @0x83006028;
	# smoke_bank3: bank=3
	register smoke_ID smoke_bank3_ID @0xc3006000;
	register smoke_STATUS smoke_bank3_STATUS @0xc3006004;
	register smoke_CFG smoke_bank3_CFG @0xc3006008;
	register smoke_FEED smoke_bank3_FEED @0xc300600c;
	register smoke_FIFO smoke_bank3_FIFO @0xc3006010;
	register smoke_CMD smoke_bank3_CMD @0xc3006014;
	register smoke_IRQ smoke_bank3_IRQ @0xc3006018;
	register smoke_BANK smoke_bank3_BANK @0xc300601c;
	register smoke_BANKSEL smoke_bank3_BANKSEL @0xc300602c;
	register smoke_ACTIVE smoke_bank3_ACTIVE @0xc3006034;
	register smoke_FABRIC smoke_bank3_FABRIC @0xc3006030;
	register smoke_key_key_0 smoke_bank3_key_key_0 @0xc3006020;
	register smoke_key_key_1 smoke_bank3_key_key_1 @0xc3006024;
	register smoke_key_key_2 smoke_bank3_key_key_2 @0xc3006028;
}
