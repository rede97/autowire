# Generated by autowire plugin wishbone (sd_sha). Do not edit.
# Register types are shared. Each bus is one block.
# TagFromAddr aliases are separate instances of that block or register.
# A pass-through child is not split; the parent names each copy.

register sha256_CTRL {
	bytes 4;
	field soft_reset @0 { bits 1; access rw; reset 0x0; }
	field done_clear @1 { bits 1; access w1c; reset 0x0; }
	field busy @8 { bits 1; access ro; reset 0x0; }
	field done @9 { bits 1; access ro; reset 0x0; }
}
register sha256_HASH0 {
	bytes 4;
	field hash0 @0 { bits 32; access ro; reset 0x0; }
}
register sha256_HASH1 {
	bytes 4;
	field hash1 @0 { bits 32; access ro; reset 0x0; }
}
register sha256_HASH2 {
	bytes 4;
	field hash2 @0 { bits 32; access ro; reset 0x0; }
}
register sha256_HASH3 {
	bytes 4;
	field hash3 @0 { bits 32; access ro; reset 0x0; }
}
register sha256_HASH4 {
	bytes 4;
	field hash4 @0 { bits 32; access ro; reset 0x0; }
}
register sha256_HASH5 {
	bytes 4;
	field hash5 @0 { bits 32; access ro; reset 0x0; }
}
register sha256_HASH6 {
	bytes 4;
	field hash6 @0 { bits 32; access ro; reset 0x0; }
}
register sha256_HASH7 {
	bytes 4;
	field hash7 @0 { bits 32; access ro; reset 0x0; }
}
block sd_sha {
	bytes 4;
	register sha256_CTRL sha256_CTRL @0x40;
	register sha256_HASH0 sha256_HASH0 @0x44;
	register sha256_HASH1 sha256_HASH1 @0x48;
	register sha256_HASH2 sha256_HASH2 @0x4c;
	register sha256_HASH3 sha256_HASH3 @0x50;
	register sha256_HASH4 sha256_HASH4 @0x54;
	register sha256_HASH5 sha256_HASH5 @0x58;
	register sha256_HASH6 sha256_HASH6 @0x5c;
	register sha256_HASH7 sha256_HASH7 @0x60;
}
